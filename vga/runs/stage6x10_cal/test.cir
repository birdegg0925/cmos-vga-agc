* CMOS VGA simulation with generic Level-1 MOS models.
.param vc=1.5 cc=1 bias=1 cl=1 g1=6 g2=10 scale=4 rin=5000 amp=0.04 freq=1000000.0 vdd=1.8 vcm=0.9 tdeg=27 dt=2 stop=40 kf=1e-25 ppd=100
.param KFL={kf}
.include ../../models/vga.lib
.options plotwinsize=0 numdgt=15 reltol=1e-5 abstol=1e-13 vntol=1e-8 chgtol=1e-20 trtol=1 method=trap
.temp {tdeg}
VDD VDD 0 {vdd}
VREF REF 0 {vcm}
VIN VIN 0 SINE({vcm} {amp/2} {freq}) AC 1
VC CTRL 0 {vc}
* Complementary control-gate driver is behavioural, no power/noise claim.
BCP CP 0 V=V(VDD)-V(CTRL)
XG VIN OUT CTRL CP REF VDD 0 VGA CC={cc*1p} BIAS={bias} CL={cl*1p} G1={g1} G2={g2} SCALE={scale} RIN={rin}
.step param vc list 1.48 1.481 1.482 1.483 1.484 1.485 1.486 1.487 1.488 1.489 1.49 1.491 1.492 1.493 1.494 1.495 1.496 1.497 1.498 1.499 1.5 1.501 1.502 1.503 1.504 1.505 1.506 1.507 1.508 1.509 1.51 1.511 1.512 1.513 1.514 1.515 1.516 1.517 1.518 1.519 1.52 1.521 1.522 1.523 1.524 1.525 1.526 1.527 1.528 1.529 1.53 1.531 1.532 1.533 1.534 1.535 1.536 1.537 1.538 1.539 1.54 1.541 1.542 1.543 1.544 1.545 1.546 1.547 1.548 1.549 1.55 1.551 1.552 1.553 1.554 1.555 1.556 1.557 1.558 1.559 1.56 1.561 1.562 1.563 1.564 1.565 1.566 1.567 1.568 1.569 1.57 1.571 1.572 1.573 1.574 1.575 1.576 1.577 1.578 1.579 1.58 1.581 1.582 1.583 1.584 1.585 1.586 1.587 1.588 1.589 1.59 1.591 1.592 1.593 1.594 1.595 1.596 1.597 1.598 1.599 1.6 1.601 1.602 1.603 1.604 1.605 1.606 1.607 1.608 1.609 1.61 1.611 1.612 1.613 1.614 1.615 1.616 1.617 1.618 1.619 1.62 1.621 1.622 1.623 1.624 1.625 1.626 1.627 1.628 1.629 1.63 1.631 1.632 1.633 1.634 1.635 1.636 1.637 1.638 1.639 1.64 1.641 1.642 1.643 1.644 1.645 1.646 1.647 1.648 1.649 1.65 1.651 1.652 1.653 1.654 1.655 1.656 1.657 1.658 1.659 1.66 1.661 1.662 1.663 1.664 1.665 1.666 1.667 1.668 1.669 1.67 1.671 1.672 1.673 1.674 1.675 1.676 1.677 1.678 1.679 1.68 1.681 1.682 1.683 1.684 1.685 1.686 1.687 1.688 1.689 1.69 1.691 1.692 1.693 1.694 1.695 1.696 1.697 1.698 1.699 1.7 1.701 1.702 1.703 1.704 1.705 1.706 1.707 1.708 1.709 1.71 1.711 1.712 1.713 1.714 1.715 1.716 1.717 1.718 1.719 1.72 1.721 1.722 1.723 1.724 1.725 1.726 1.727 1.728 1.729 1.73 1.731 1.732 1.733 1.734 1.735 1.736 1.737 1.738 1.739 1.74 1.741 1.742 1.743 1.744 1.745 1.746 1.747 1.748 1.749 1.75 1.751 1.752 1.753 1.754 1.755 1.756 1.757 1.758 1.759 1.76 1.761 1.762 1.763 1.764 1.765 1.766 1.767 1.768 1.769 1.77 1.771 1.772 1.773 1.774 1.775 1.776 1.777 1.778 1.779 1.78 1.781 1.782 1.783 1.784 1.785 1.786 1.787 1.788 1.789 1.79 1.791 1.792 1.793 1.794 1.795 1.796 1.797 1.798 1.799 1.8
.ac lin 1 1Meg 1Meg
.save V(OUT) V(VIN) V(xg:att) V(xg:mid) I(VIN)
CDET OUT SENSE 10p
RDET SENSE 0 1Meg
.end
