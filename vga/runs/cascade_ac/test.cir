* CMOS VGA simulation with generic Level-1 MOS models.
.param vc={table(testcase,0,1.7859508609292825,1,1.5462135126960361,2,1.4862789322073584)} cc=1 bias=1 cl=1 g1=8 g2=8 scale=4 rin=5000 amp=0.04 freq=1000000.0 vdd=1.8 vcm=0.9 tdeg=27 dt=2 stop=40 kf=1e-25 ppd=160
.param KFL={kf}
.include ../../models/vga.lib
.options plotwinsize=0 numdgt=15 reltol=1e-5 abstol=1e-13 vntol=1e-8 chgtol=1e-20 trtol=1 method=trap
.temp {tdeg}
VDD VDD 0 {vdd}
VREF REF 0 {vcm}
CCOUP TI_OUT VIN 10n
RBIAS VIN REF 1Meg
VC CTRL 0 {vc}
* Complementary control-gate driver is behavioural, no power/noise claim.
BCP CP 0 V=V(VDD)-V(CTRL)
XG VIN OUT CTRL CP REF VDD 0 VGA CC={cc*1p} BIAS={bias} CL={cl*1p} G1={g1} G2={g2} SCALE={scale} RIN={rin}
.ac dec {ppd} 10 1G
.save V(TI_OUT) V(DET) I(VDDTIA) I(ISIGNAL) V(OUT) V(VIN) V(xg:att) V(xg:mid)
CDET OUT SENSE 10p
RDET SENSE 0 1Meg
.step param testcase 0 2 1
.param ipp=1e-06

.include ../../models/original_tia.lib
VDDTIA VDDT 0 1.8
VREFTIA REFT 0 .9
IDARK DET 0 20n
IBACK DET 0 1.98u
ISIGNAL DET 0 SINE(0 {ipp/2} 1Meg) AC 1
CD DET 0 3.54e-12
RFTIA TI_OUT DET 81600.0
CFTIA TI_OUT DET 3.6e-13
XTIA REFT DET TI_OUT VDDT 0 CMOS_OPAMP CCOMP=1p BIAS_SCALE=1
CLTIA TI_OUT 0 1p
.end
